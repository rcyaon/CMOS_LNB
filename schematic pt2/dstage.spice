* dstage -- regenerated from dstage.sch (see sch2spice.py)
.subckt dstage inp inn outp outn vdd nb cw=5.15u rl=5.5u wt=50u
XC1 outn 0 cap_mim_2f0fF c_width=cw c_length=cw m=1
XC2 outp 0 cap_mim_2f0fF c_width=cw c_length=cw m=1
XM1 outn inp net1 0 nfet_03v3 L=0.28u W=20u nf=1 m=1
+ ad='int((nf+1)/2) * W/nf * 0.18u' as='int((nf+2)/2) * W/nf * 0.18u'
+ pd='2*int((nf+1)/2) * (W/nf + 0.18u)' ps='2*int((nf+2)/2) * (W/nf + 0.18u)'
+ nrd='0.18u / W' nrs='0.18u / W' sa=0 sb=0 sd=0
XM2 net1 inn outp 0 nfet_03v3 L=0.28u W=20u nf=1 m=1
+ ad='int((nf+1)/2) * W/nf * 0.18u' as='int((nf+2)/2) * W/nf * 0.18u'
+ pd='2*int((nf+1)/2) * (W/nf + 0.18u)' ps='2*int((nf+2)/2) * (W/nf + 0.18u)'
+ nrd='0.18u / W' nrs='0.18u / W' sa=0 sb=0 sd=0
XM3 net1 nb 0 0 nfet_03v3 L=1u W=wt nf=1 m=1
+ ad='int((nf+1)/2) * W/nf * 0.18u' as='int((nf+2)/2) * W/nf * 0.18u'
+ pd='2*int((nf+1)/2) * (W/nf + 0.18u)' ps='2*int((nf+2)/2) * (W/nf + 0.18u)'
+ nrd='0.18u / W' nrs='0.18u / W' sa=0 sb=0 sd=0
XR1 vdd outn 0 ppolyf_u_1k r_width=2u r_length=rl m=1
XR2 vdd outp 0 ppolyf_u_1k r_width=2u r_length=rl m=1
.ends dstage
