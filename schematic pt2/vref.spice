* vref -- regenerated from vref.sch (see sch2spice.py)
.subckt vref vdd pg o07 o20 o30 l1=34.26u l2=64.23u l3=49.31u
XC1 o20 0 cap_mim_2f0fF c_width=22u c_length=22u m=1
XC3 o07 0 cap_mim_2f0fF c_width=22u c_length=22u m=1
XC4 o30 0 cap_mim_2f0fF c_width=22u c_length=22u m=1
XM1 vdd pg net1 vdd pfet_06v0 L=2u W=40u nf=1 m=1
+ ad='int((nf+1)/2) * W/nf * 0.18u' as='int((nf+2)/2) * W/nf * 0.18u'
+ pd='2*int((nf+1)/2) * (W/nf + 0.18u)' ps='2*int((nf+2)/2) * (W/nf + 0.18u)'
+ nrd='0.18u / W' nrs='0.18u / W' sa=0 sb=0 sd=0
XR1 net2 0 0 ppolyf_u_1k r_width=1e-6 r_length=l1 m=1
XR2 net3 net2 0 ppolyf_u_1k r_width=1e-6 r_length=l2 m=1
XR3 net3 net1 0 ppolyf_u_1k r_width=1e-6 r_length=l3 m=1
x1 o20 vdd pg net3 ota5
x4 o30 vdd pg net1 ota5
x5 o07 vdd pg net2 ota5
.ends vref
