* LVS reference for Layout/ErrorAmplifierNMOSMkI.gds, from
* Schematic/Error Amplifier/ErrorAmplifierNMOSMkI.sch (qucs-s -n --ngspice).
* Ports in symbol order; VSS is the schematic's global ground (node 0).
.subckt ErrorAmplifierNMOSMkI Input Com Output VDD TBias VSS
M1 VDD mirror mirror VDD pfet_06v0 L=4u W=10u
M2 VDD mirror Output VDD pfet_06v0 L=4u W=10u
M3 Output Com tail VSS nfet_06v0 L=4u W=10u
M4 tail TBias VSS VSS nfet_06v0 L=4u W=10u
M5 mirror Input tail VSS nfet_06v0 L=4u W=10u
.ends
