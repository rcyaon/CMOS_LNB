* NGSPICE file created from ReferenceMkII_pex.ext - technology: gf180mcuD

.subckt ReferenceMkII_pex Out TBias BandGap VDD VSS
X0 VDD a_12516_3518# a_12516_3518# VDD pfet_06v0 ad=2.6p pd=10.52u as=7.7p ps=21.54u w=10u l=4u
X1 a_714_500# a_12516_3518# VDD VDD pfet_06v0 ad=7.7p pd=21.54u as=2.6p ps=10.52u w=10u l=4u
X2 Out a_4852_5448# cap_mim_2f0_m4m5_noshield c_width=22u c_length=11u
X3 a_714_500# BandGap a_11974_574# VSS.t0 nfet_06v0 ad=7.3p pd=21.46u as=2.6p ps=10.52u w=10u l=4u
X4 a_4852_5448# VSS.t6 VSS.t2 ppolyf_u_1k r_width=1u r_length=24u
X5 a_11974_574# a_4852_5448# a_12516_3518# VSS.t1 nfet_06v0 ad=2.6p pd=10.52u as=7.3p ps=21.46u w=10u l=4u
X6 VDD a_714_500# Out VDD pfet_06v0 ad=15.4p pd=41.54u as=5.2p ps=20.52u w=20u l=10u
X7 a_11974_574# TBias VSS.t4 VSS.t5 nfet_06v0 ad=7.3p pd=21.46u as=2.6p ps=10.52u w=10u l=4u
X8 Out a_714_500# VDD VDD pfet_06v0 ad=5.2p pd=20.52u as=15.4p ps=41.54u w=20u l=10u
X9 Out a_714_500# VDD VDD pfet_06v0 ad=5.2p pd=20.52u as=5.2p ps=20.52u w=20u l=10u
X10 VSS.t4 TBias TBias VSS.t3 nfet_06v0 ad=2.6p pd=10.52u as=7.3p ps=21.46u w=10u l=4u
X11 Out a_4852_5448# VSS.t2 ppolyf_u_1k r_width=1u r_length=10u
X12 VDD a_714_500# Out VDD pfet_06v0 ad=5.2p pd=20.52u as=5.2p ps=20.52u w=20u l=10u
R0 VSS.t1 VSS.t0 933.885
R1 VSS.t3 VSS.n28 818.183
R2 VSS.n42 VSS.t0 818.183
R3 VSS.n9 VSS.t5 770.662
R4 VSS.n9 VSS.t1 770.662
R5 VSS.t5 VSS.t2 704.545
R6 VSS.t2 VSS.t3 229.339
R7 VSS.n34 VSS.n9 190.142
R8 VSS.n2 VSS.n9 1.7483
R9 VSS.n7 VSS.n14 5.36909
R10 VSS.n43 VSS.n15 7.91354
R11 VSS.n5 VSS.n17 5.50844
R12 VSS.n8 VSS.n37 4.48301
R13 VSS.n11 VSS.n31 4.48301
R14 VSS.n13 VSS.n38 4.48301
R15 VSS.n16 VSS.n43 2.23559
R16 VSS.n17 VSS.n25 4.48301
R17 VSS.n18 VSS.n35 4.48301
R18 VSS.n19 VSS.n33 4.48301
R19 VSS.n20 VSS.n36 4.48301
R20 VSS.n12 VSS.n32 4.48301
R21 VSS.n42 VSS.n7 0.344908
R22 VSS.n3 VSS.n14 1.4837
R23 VSS.n10 VSS.n27 4.48301
R24 VSS.n10 VSS.n3 1.4837
R25 VSS.n3 VSS.n15 5.2005
R26 VSS.n43 VSS.n42 5.2005
R27 VSS.n16 VSS.n3 1.4837
R28 VSS.n17 VSS.n3 1.4837
R29 VSS.n42 VSS.n5 0.176715
R30 VSS.n4 VSS.n5 0.850246
R31 VSS.n2 VSS.n41 7.26348
R32 VSS.n24 VSS.t6 1.4837
R33 VSS.n40 VSS.n24 4.48301
R34 VSS.n23 VSS.t6 1.4837
R35 VSS.n23 VSS.n29 4.48301
R36 VSS.n1 VSS.n22 1.4837
R37 VSS.n39 VSS.n22 4.48301
R38 VSS.n21 VSS.n1 1.4837
R39 VSS.n21 VSS.n30 4.47069
R40 VSS.n13 VSS.n0 1.47754
R41 VSS.n0 VSS.n11 1.47754
R42 VSS.n8 VSS.n0 1.47754
R43 VSS.n0 VSS.n12 1.4837
R44 VSS.n20 VSS.n0 1.4837
R45 VSS.n0 VSS.n19 1.4837
R46 VSS.n18 VSS.n0 1.4837
R47 VSS.n34 VSS.n0 5.2005
R48 VSS.n9 VSS.n6 2.35118
R49 VSS.n4 VSS.n9 2.35118
R50 VSS.n14 VSS.n27 4.48301
R51 VSS.n16 VSS.n25 4.48301
R52 VSS.n35 VSS.n34 2.24791
R53 VSS.n18 VSS.n33 4.48301
R54 VSS.n36 VSS.n19 4.48301
R55 VSS.n20 VSS.n32 4.48301
R56 VSS.n39 VSS.n21 4.48301
R57 VSS.n22 VSS.n29 4.48301
R58 VSS.n40 VSS.n23 4.48301
R59 VSS.n41 VSS.n24 4.48301
R60 VSS.n26 VSS.n15 2.23559
R61 VSS.n10 VSS.n26 4.47069
R62 VSS.n37 VSS.n12 4.47069
R63 VSS.n8 VSS.n31 4.48301
R64 VSS.n38 VSS.n11 4.48301
R65 VSS.n13 VSS.n30 4.48301
R66 VSS.n2 VSS.t6 0.0487854
R67 VSS.t4 VSS.n9 1.57246
R68 VSS.n7 VSS.n6 1.6634
R69 VSS.n1 VSS.n0 1.61952
R70 VSS.n42 VSS.n26 1.4837
R71 VSS.n30 VSS.n28 1.4837
R72 VSS.n38 VSS.n28 1.4837
R73 VSS.n31 VSS.n28 1.4837
R74 VSS.n37 VSS.n28 1.4837
R75 VSS.n42 VSS.n27 1.47754
R76 VSS.n42 VSS.n25 1.47754
R77 VSS.n41 VSS.n28 1.47754
R78 VSS.n40 VSS.n28 1.47754
R79 VSS.n29 VSS.n28 1.47754
R80 VSS.n39 VSS.n28 1.47754
R81 VSS.n32 VSS.n28 1.47754
R82 VSS.n36 VSS.n28 1.47754
R83 VSS.n33 VSS.n28 1.47754
R84 VSS.n35 VSS.n28 1.47754
R85 VSS.n4 VSS.n3 1.38103
R86 VSS.t6 VSS.n1 1.34267
R87 VSS.n0 VSS.t4 1.27322
R88 VSS.n6 VSS.n3 1.07777
R89 VSS VSS.n0 0.0005
C0 TBias VDD 0.02788f
C1 VDD a_714_500# 15.2845f
C2 a_12516_3518# VDD 3.90155f
C3 a_4852_5448# VDD 0.86892f
C4 VDD Out 1.26776f
C5 BandGap VDD 0.01033f
C6 TBias a_714_500# 0.13813f
C7 a_12516_3518# TBias 0.03982f
C8 a_12516_3518# a_714_500# 0.57021f
C9 a_4852_5448# TBias 0.05669f
C10 a_4852_5448# a_714_500# 1.72542f
C11 a_11974_574# TBias 0.31557f
C12 a_11974_574# a_714_500# 0.07282f
C13 a_4852_5448# a_12516_3518# 0.84463f
C14 a_12516_3518# a_11974_574# 0.28427f
C15 Out a_714_500# 9.80231f
C16 BandGap a_714_500# 0.43749f
C17 a_12516_3518# BandGap 0.02228f
C18 a_4852_5448# a_11974_574# 0.75154f
C19 a_4852_5448# Out 1.66935f
C20 a_4852_5448# BandGap 0.12441f
C21 a_11974_574# BandGap 0.38185f
C22 Out VSS 2.01985f
C23 VDD VSS 0.17467p
C24 a_11974_574# VSS 8.681f
C25 a_12516_3518# VSS 5.10121f
C26 VSS.t4 VSS 2.21284f
.ends
