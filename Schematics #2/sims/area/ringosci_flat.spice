* ringosci -- flattened for sch-area-estimator (sizes in um)
X0 x1.XM1 gf180mcu_fd_pr__nfet_06v0 w=2 l=0.7 nf=1 m=1
X1 x1.XM2 gf180mcu_fd_pr__pfet_06v0 w=5 l=0.55 nf=1 m=1
X2 x2.XM1 gf180mcu_fd_pr__nfet_06v0 w=2 l=0.7 nf=1 m=1
X3 x2.XM2 gf180mcu_fd_pr__pfet_06v0 w=5 l=0.55 nf=1 m=1
X4 x3.XM1 gf180mcu_fd_pr__nfet_06v0 w=2 l=0.7 nf=1 m=1
X5 x3.XM2 gf180mcu_fd_pr__pfet_06v0 w=5 l=0.55 nf=1 m=1
